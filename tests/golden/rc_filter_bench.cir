.title rc_filter
C1 /OUT 0 100n
R1 /IN /OUT 10k
V1 /IN 0 DC 0 AC 1
.end
